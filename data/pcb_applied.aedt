# Ansys Electronics Desktop project, version 2025.1
materials:
  AIR: permittivity=1 permeability=1
  BOTTOM_FILL: permittivity=4.5 permeability=1
  COPPER: conductivity=59590000
  FR-4: permittivity=3.86 permeability=1 dielectric_loss_tangent=0.024
  FR-4_1: permittivity=4.34 permeability=1 dielectric_loss_tangent=0.018
  FR-4_2: permittivity=4.5 permeability=1 dielectric_loss_tangent=0.035
  FR4_epoxy: permittivity=4.4 dielectric_loss_tangent=0.02
  GND_FILL: permittivity=4.5 permeability=1 dielectric_loss_tangent=0.035
  LYR_1_FILL: permittivity=4.5 permeability=1 dielectric_loss_tangent=0.035
  LYR_2_FILL: permittivity=4.5 permeability=1 dielectric_loss_tangent=0.035
  PWR_FILL: permittivity=4.5 permeability=1 dielectric_loss_tangent=0.035
  TOP_FILL: permittivity=4.5 permeability=1

design Galileo_G87173_204 (HFSS 3D Layout)
nets:
  M_DQ<0>: port 1_U2A5_M_DQ<0>, port 2_U1B5_M_DQ<0>
  M_DQ<10>: port 3_U2A5_M_DQ<10>, port 4_U1A1_M_DQ<10>
  M_DQ<11>: port 5_U2A5_M_DQ<11>, port 6_U1A1_M_DQ<11>
  M_DQ<12>: port 7_U2A5_M_DQ<12>, port 8_U1A1_M_DQ<12>
  M_DQ<13>: port 9_U2A5_M_DQ<13>, port 10_U1A1_M_DQ<13>
  M_DQ<14>: port 11_U2A5_M_DQ<14>, port 12_U1A1_M_DQ<14>
  M_DQ<15>: port 13_U2A5_M_DQ<15>, port 14_U1A1_M_DQ<15>
  M_DQ<1>: port 15_U2A5_M_DQ<1>, port 16_U1B5_M_DQ<1>
  M_DQ<2>: port 17_U2A5_M_DQ<2>, port 18_U1B5_M_DQ<2>
  M_DQ<3>: port 19_U2A5_M_DQ<3>, port 20_U1B5_M_DQ<3>
  M_DQ<4>: port 21_U2A5_M_DQ<4>, port 22_U1B5_M_DQ<4>
  M_DQ<5>: port 23_U2A5_M_DQ<5>, port 24_U1B5_M_DQ<5>
  M_DQ<6>: port 25_U2A5_M_DQ<6>, port 26_U1B5_M_DQ<6>
  M_DQ<7>: port 27_U2A5_M_DQ<7>, port 28_U1B5_M_DQ<7>
  M_DQ<8>: port 29_U2A5_M_DQ<8>, port 30_U1A1_M_DQ<8>
  M_DQ<9>: port 31_U2A5_M_DQ<9>, port 32_U1A1_M_DQ<9>
  M_DQS<0>: port 35_U2A5_M_DQS<0>, port 36_U1B5_M_DQS<0>
  M_DQS<1>: port 39_U2A5_M_DQS<1>, port 40_U1A1_M_DQS<1>
  M_DQS_N<0>: port 33_U2A5_M_DQS_N<0>, port 34_U1B5_M_DQS_N<0>
  M_DQS_N<1>: port 37_U2A5_M_DQS_N<1>, port 38_U1A1_M_DQS_N<1>
ports:
  10_U1A1_M_DQ<13>: Properties{Override_Impedance Impedance=50 Magnitude=0V Phase=0deg Renormalize_Impedence=50ohm Deembed_Distance=0mm Layer_Alignment=Upper Horizontal_Extent_Factor=5 Vertical_Extent_Factor=3 PEC_Launch_Width=0mm Reference_Net=GND} Type=EdgePort Pin=10_U1A1_M_DQ<13> CircuitPort
  11_U2A5_M_DQ<14>: Properties{Override_Impedance Impedance=50 Magnitude=0V Phase=0deg Renormalize_Impedence=50ohm Deembed_Distance=0mm Layer_Alignment=Upper Horizontal_Extent_Factor=5 Vertical_Extent_Factor=3 PEC_Launch_Width=0mm Reference_Net=GND} Type=EdgePort Pin=11_U2A5_M_DQ<14> CircuitPort
  12_U1A1_M_DQ<14>: Properties{Override_Impedance Impedance=50 Magnitude=0V Phase=0deg Renormalize_Impedence=50ohm Deembed_Distance=0mm Layer_Alignment=Upper Horizontal_Extent_Factor=5 Vertical_Extent_Factor=3 PEC_Launch_Width=0mm Reference_Net=GND} Type=EdgePort Pin=12_U1A1_M_DQ<14> CircuitPort
  13_U2A5_M_DQ<15>: Properties{Override_Impedance Impedance=50 Magnitude=0V Phase=0deg Renormalize_Impedence=50ohm Deembed_Distance=0mm Layer_Alignment=Upper Horizontal_Extent_Factor=5 Vertical_Extent_Factor=3 PEC_Launch_Width=0mm Reference_Net=GND} Type=EdgePort Pin=13_U2A5_M_DQ<15> CircuitPort
  14_U1A1_M_DQ<15>: Properties{Override_Impedance Impedance=50 Magnitude=0V Phase=0deg Renormalize_Impedence=50ohm Deembed_Distance=0mm Layer_Alignment=Upper Horizontal_Extent_Factor=5 Vertical_Extent_Factor=3 PEC_Launch_Width=0mm Reference_Net=GND} Type=EdgePort Pin=14_U1A1_M_DQ<15> CircuitPort
  15_U2A5_M_DQ<1>: Properties{Override_Impedance Impedance=50 Magnitude=0V Phase=0deg Renormalize_Impedence=50ohm Deembed_Distance=0mm Layer_Alignment=Upper Horizontal_Extent_Factor=5 Vertical_Extent_Factor=3 PEC_Launch_Width=0mm Reference_Net=GND} Type=EdgePort Pin=15_U2A5_M_DQ<1> CircuitPort
  16_U1B5_M_DQ<1>: Properties{Override_Impedance Impedance=50 Magnitude=0V Phase=0deg Renormalize_Impedence=50ohm Deembed_Distance=0mm Layer_Alignment=Upper Horizontal_Extent_Factor=5 Vertical_Extent_Factor=3 PEC_Launch_Width=0mm Reference_Net=GND} Type=EdgePort Pin=16_U1B5_M_DQ<1> CircuitPort
  17_U2A5_M_DQ<2>: Properties{Override_Impedance Impedance=50 Magnitude=0V Phase=0deg Renormalize_Impedence=50ohm Deembed_Distance=0mm Layer_Alignment=Upper Horizontal_Extent_Factor=5 Vertical_Extent_Factor=3 PEC_Launch_Width=0mm Reference_Net=GND} Type=EdgePort Pin=17_U2A5_M_DQ<2> CircuitPort
  18_U1B5_M_DQ<2>: Properties{Override_Impedance Impedance=50 Magnitude=0V Phase=0deg Renormalize_Impedence=50ohm Deembed_Distance=0mm Layer_Alignment=Upper Horizontal_Extent_Factor=5 Vertical_Extent_Factor=3 PEC_Launch_Width=0mm Reference_Net=GND} Type=EdgePort Pin=18_U1B5_M_DQ<2> CircuitPort
  19_U2A5_M_DQ<3>: Properties{Override_Impedance Impedance=50 Magnitude=0V Phase=0deg Renormalize_Impedence=50ohm Deembed_Distance=0mm Layer_Alignment=Upper Horizontal_Extent_Factor=5 Vertical_Extent_Factor=3 PEC_Launch_Width=0mm Reference_Net=GND} Type=EdgePort Pin=19_U2A5_M_DQ<3> CircuitPort
  1_U2A5_M_DQ<0>: Properties{Override_Impedance Impedance=50 Magnitude=0V Phase=0deg Renormalize_Impedence=50ohm Deembed_Distance=0mm Layer_Alignment=Upper Horizontal_Extent_Factor=5 Vertical_Extent_Factor=3 PEC_Launch_Width=0mm Reference_Net=GND} Type=EdgePort Pin=1_U2A5_M_DQ<0> CircuitPort
  20_U1B5_M_DQ<3>: Properties{Override_Impedance Impedance=50 Magnitude=0V Phase=0deg Renormalize_Impedence=50ohm Deembed_Distance=0mm Layer_Alignment=Upper Horizontal_Extent_Factor=5 Vertical_Extent_Factor=3 PEC_Launch_Width=0mm Reference_Net=GND} Type=EdgePort Pin=20_U1B5_M_DQ<3> CircuitPort
  21_U2A5_M_DQ<4>: Properties{Override_Impedance Impedance=50 Magnitude=0V Phase=0deg Renormalize_Impedence=50ohm Deembed_Distance=0mm Layer_Alignment=Upper Horizontal_Extent_Factor=5 Vertical_Extent_Factor=3 PEC_Launch_Width=0mm Reference_Net=GND} Type=EdgePort Pin=21_U2A5_M_DQ<4> CircuitPort
  22_U1B5_M_DQ<4>: Properties{Override_Impedance Impedance=50 Magnitude=0V Phase=0deg Renormalize_Impedence=50ohm Deembed_Distance=0mm Layer_Alignment=Upper Horizontal_Extent_Factor=5 Vertical_Extent_Factor=3 PEC_Launch_Width=0mm Reference_Net=GND} Type=EdgePort Pin=22_U1B5_M_DQ<4> CircuitPort
  23_U2A5_M_DQ<5>: Properties{Override_Impedance Impedance=50 Magnitude=0V Phase=0deg Renormalize_Impedence=50ohm Deembed_Distance=0mm Layer_Alignment=Upper Horizontal_Extent_Factor=5 Vertical_Extent_Factor=3 PEC_Launch_Width=0mm Reference_Net=GND} Type=EdgePort Pin=23_U2A5_M_DQ<5> CircuitPort
  24_U1B5_M_DQ<5>: Properties{Override_Impedance Impedance=50 Magnitude=0V Phase=0deg Renormalize_Impedence=50ohm Deembed_Distance=0mm Layer_Alignment=Upper Horizontal_Extent_Factor=5 Vertical_Extent_Factor=3 PEC_Launch_Width=0mm Reference_Net=GND} Type=EdgePort Pin=24_U1B5_M_DQ<5> CircuitPort
  25_U2A5_M_DQ<6>: Properties{Override_Impedance Impedance=50 Magnitude=0V Phase=0deg Renormalize_Impedence=50ohm Deembed_Distance=0mm Layer_Alignment=Upper Horizontal_Extent_Factor=5 Vertical_Extent_Factor=3 PEC_Launch_Width=0mm Reference_Net=GND} Type=EdgePort Pin=25_U2A5_M_DQ<6> CircuitPort
  26_U1B5_M_DQ<6>: Properties{Override_Impedance Impedance=50 Magnitude=0V Phase=0deg Renormalize_Impedence=50ohm Deembed_Distance=0mm Layer_Alignment=Upper Horizontal_Extent_Factor=5 Vertical_Extent_Factor=3 PEC_Launch_Width=0mm Reference_Net=GND} Type=EdgePort Pin=26_U1B5_M_DQ<6> CircuitPort
  27_U2A5_M_DQ<7>: Properties{Override_Impedance Impedance=50 Magnitude=0V Phase=0deg Renormalize_Impedence=50ohm Deembed_Distance=0mm Layer_Alignment=Upper Horizontal_Extent_Factor=5 Vertical_Extent_Factor=3 PEC_Launch_Width=0mm Reference_Net=GND} Type=EdgePort Pin=27_U2A5_M_DQ<7> CircuitPort
  28_U1B5_M_DQ<7>: Properties{Override_Impedance Impedance=50 Magnitude=0V Phase=0deg Renormalize_Impedence=50ohm Deembed_Distance=0mm Layer_Alignment=Upper Horizontal_Extent_Factor=5 Vertical_Extent_Factor=3 PEC_Launch_Width=0mm Reference_Net=GND} Type=EdgePort Pin=28_U1B5_M_DQ<7> CircuitPort
  29_U2A5_M_DQ<8>: Properties{Override_Impedance Impedance=50 Magnitude=0V Phase=0deg Renormalize_Impedence=50ohm Deembed_Distance=0mm Layer_Alignment=Upper Horizontal_Extent_Factor=5 Vertical_Extent_Factor=3 PEC_Launch_Width=0mm Reference_Net=GND} Type=EdgePort Pin=29_U2A5_M_DQ<8> CircuitPort
  2_U1B5_M_DQ<0>: Properties{Override_Impedance Impedance=50 Magnitude=0V Phase=0deg Renormalize_Impedence=50ohm Deembed_Distance=0mm Layer_Alignment=Upper Horizontal_Extent_Factor=5 Vertical_Extent_Factor=3 PEC_Launch_Width=0mm Reference_Net=GND} Type=EdgePort Pin=2_U1B5_M_DQ<0> CircuitPort
  30_U1A1_M_DQ<8>: Properties{Override_Impedance Impedance=50 Magnitude=0V Phase=0deg Renormalize_Impedence=50ohm Deembed_Distance=0mm Layer_Alignment=Upper Horizontal_Extent_Factor=5 Vertical_Extent_Factor=3 PEC_Launch_Width=0mm Reference_Net=GND} Type=EdgePort Pin=30_U1A1_M_DQ<8> CircuitPort
  31_U2A5_M_DQ<9>: Properties{Override_Impedance Impedance=50 Magnitude=0V Phase=0deg Renormalize_Impedence=50ohm Deembed_Distance=0mm Layer_Alignment=Upper Horizontal_Extent_Factor=5 Vertical_Extent_Factor=3 PEC_Launch_Width=0mm Reference_Net=GND} Type=EdgePort Pin=31_U2A5_M_DQ<9> CircuitPort
  32_U1A1_M_DQ<9>: Properties{Override_Impedance Impedance=50 Magnitude=0V Phase=0deg Renormalize_Impedence=50ohm Deembed_Distance=0mm Layer_Alignment=Upper Horizontal_Extent_Factor=5 Vertical_Extent_Factor=3 PEC_Launch_Width=0mm Reference_Net=GND} Type=EdgePort Pin=32_U1A1_M_DQ<9> CircuitPort
  33_U2A5_M_DQS_N<0>: Properties{Override_Impedance Impedance=50 Magnitude=0V Phase=0deg Renormalize_Impedence=50ohm Deembed_Distance=0mm Layer_Alignment=Upper Horizontal_Extent_Factor=5 Vertical_Extent_Factor=3 PEC_Launch_Width=0mm Reference_Net=GND} Type=EdgePort Pin=33_U2A5_M_DQS_N<0> CircuitPort
  34_U1B5_M_DQS_N<0>: Properties{Override_Impedance Impedance=50 Magnitude=0V Phase=0deg Renormalize_Impedence=50ohm Deembed_Distance=0mm Layer_Alignment=Upper Horizontal_Extent_Factor=5 Vertical_Extent_Factor=3 PEC_Launch_Width=0mm Reference_Net=GND} Type=EdgePort Pin=34_U1B5_M_DQS_N<0> CircuitPort
  35_U2A5_M_DQS<0>: Properties{Override_Impedance Impedance=50 Magnitude=0V Phase=0deg Renormalize_Impedence=50ohm Deembed_Distance=0mm Layer_Alignment=Upper Horizontal_Extent_Factor=5 Vertical_Extent_Factor=3 PEC_Launch_Width=0mm Reference_Net=GND} Type=EdgePort Pin=35_U2A5_M_DQS<0> CircuitPort
  36_U1B5_M_DQS<0>: Properties{Override_Impedance Impedance=50 Magnitude=0V Phase=0deg Renormalize_Impedence=50ohm Deembed_Distance=0mm Layer_Alignment=Upper Horizontal_Extent_Factor=5 Vertical_Extent_Factor=3 PEC_Launch_Width=0mm Reference_Net=GND} Type=EdgePort Pin=36_U1B5_M_DQS<0> CircuitPort
  37_U2A5_M_DQS_N<1>: Properties{Override_Impedance Impedance=50 Magnitude=0V Phase=0deg Renormalize_Impedence=50ohm Deembed_Distance=0mm Layer_Alignment=Upper Horizontal_Extent_Factor=5 Vertical_Extent_Factor=3 PEC_Launch_Width=0mm Reference_Net=GND} Type=EdgePort Pin=37_U2A5_M_DQS_N<1> CircuitPort
  38_U1A1_M_DQS_N<1>: Properties{Override_Impedance Impedance=50 Magnitude=0V Phase=0deg Renormalize_Impedence=50ohm Deembed_Distance=0mm Layer_Alignment=Upper Horizontal_Extent_Factor=5 Vertical_Extent_Factor=3 PEC_Launch_Width=0mm Reference_Net=GND} Type=EdgePort Pin=38_U1A1_M_DQS_N<1> CircuitPort
  39_U2A5_M_DQS<1>: Properties{Override_Impedance Impedance=50 Magnitude=0V Phase=0deg Renormalize_Impedence=50ohm Deembed_Distance=0mm Layer_Alignment=Upper Horizontal_Extent_Factor=5 Vertical_Extent_Factor=3 PEC_Launch_Width=0mm Reference_Net=GND} Type=EdgePort Pin=39_U2A5_M_DQS<1> CircuitPort
  3_U2A5_M_DQ<10>: Properties{Override_Impedance Impedance=50 Magnitude=0V Phase=0deg Renormalize_Impedence=50ohm Deembed_Distance=0mm Layer_Alignment=Upper Horizontal_Extent_Factor=5 Vertical_Extent_Factor=3 PEC_Launch_Width=0mm Reference_Net=GND} Type=EdgePort Pin=3_U2A5_M_DQ<10> CircuitPort
  40_U1A1_M_DQS<1>: Properties{Override_Impedance Impedance=50 Magnitude=0V Phase=0deg Renormalize_Impedence=50ohm Deembed_Distance=0mm Layer_Alignment=Upper Horizontal_Extent_Factor=5 Vertical_Extent_Factor=3 PEC_Launch_Width=0mm Reference_Net=GND} Type=EdgePort Pin=40_U1A1_M_DQS<1> CircuitPort
  4_U1A1_M_DQ<10>: Properties{Override_Impedance Impedance=50 Magnitude=0V Phase=0deg Renormalize_Impedence=50ohm Deembed_Distance=0mm Layer_Alignment=Upper Horizontal_Extent_Factor=5 Vertical_Extent_Factor=3 PEC_Launch_Width=0mm Reference_Net=GND} Type=EdgePort Pin=4_U1A1_M_DQ<10> CircuitPort
  5_U2A5_M_DQ<11>: Properties{Override_Impedance Impedance=50 Magnitude=0V Phase=0deg Renormalize_Impedence=50ohm Deembed_Distance=0mm Layer_Alignment=Upper Horizontal_Extent_Factor=5 Vertical_Extent_Factor=3 PEC_Launch_Width=0mm Reference_Net=GND} Type=EdgePort Pin=5_U2A5_M_DQ<11> CircuitPort
  6_U1A1_M_DQ<11>: Properties{Override_Impedance Impedance=50 Magnitude=0V Phase=0deg Renormalize_Impedence=50ohm Deembed_Distance=0mm Layer_Alignment=Upper Horizontal_Extent_Factor=5 Vertical_Extent_Factor=3 PEC_Launch_Width=0mm Reference_Net=GND} Type=EdgePort Pin=6_U1A1_M_DQ<11> CircuitPort
  7_U2A5_M_DQ<12>: Properties{Override_Impedance Impedance=50 Magnitude=0V Phase=0deg Renormalize_Impedence=50ohm Deembed_Distance=0mm Layer_Alignment=Upper Horizontal_Extent_Factor=5 Vertical_Extent_Factor=3 PEC_Launch_Width=0mm Reference_Net=GND} Type=EdgePort Pin=7_U2A5_M_DQ<12> CircuitPort
  8_U1A1_M_DQ<12>: Properties{Override_Impedance Impedance=50 Magnitude=0V Phase=0deg Renormalize_Impedence=50ohm Deembed_Distance=0mm Layer_Alignment=Upper Horizontal_Extent_Factor=5 Vertical_Extent_Factor=3 PEC_Launch_Width=0mm Reference_Net=GND} Type=EdgePort Pin=8_U1A1_M_DQ<12> CircuitPort
  9_U2A5_M_DQ<13>: Properties{Override_Impedance Impedance=50 Magnitude=0V Phase=0deg Renormalize_Impedence=50ohm Deembed_Distance=0mm Layer_Alignment=Upper Horizontal_Extent_Factor=5 Vertical_Extent_Factor=3 PEC_Launch_Width=0mm Reference_Net=GND} Type=EdgePort Pin=9_U2A5_M_DQ<13> CircuitPort
setups:
  Siwave_SYZ_GFW0DW: SolveSetupType=SIwave
    sweep sweep_I3V8B3: LINC 0.0GHz 1e-06GHz 3 DEC 1e-06GHz 0.1GHz 10 LIN 0.1GHz 10.0GHz 0.1GHz;
  Siwave_SYZ_KF5VET: SolveSetupType=SIwave
    sweep sweep_2A8PVK: LINC 0.0GHz 1e-06GHz 3 DEC 1e-06GHz 0.1GHz 10 LIN 0.1GHz 10.0GHz 0.1GHz;
